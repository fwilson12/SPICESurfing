.title CMOS_4to1_MUX_Transmission_Gates

Vdd Vdd 0 1.8V

Vin Vin 0 0.9V

Vd1 D1 0 1.8V

Vd2 D2 0 0.0V

Vd3 D3 0 1.8V

Vs0 S0 0 0.0V

Vs1 S1 0 0.0V

MINV_S0_P S0_bar S0 Vdd Vdd PMOS l=1.8e-07 w=1e-06

MINV_S0_N S0_bar S0 0 0 NMOS l=1.8e-07 w=5e-07

MINV_S1_P S1_bar S1 Vdd Vdd PMOS l=1.8e-07 w=1e-06

MINV_S1_N S1_bar S1 0 0 NMOS l=1.8e-07 w=5e-07

MSEL0_NAND_P1 SEL0_NAND_OUT S1_bar Vdd Vdd PMOS l=1.8e-07 w=1e-06

MSEL0_NAND_P2 SEL0_NAND_OUT S0_bar Vdd Vdd PMOS l=1.8e-07 w=1e-06

MSEL0_NAND_N1 SEL0_NAND_OUT S1_bar SEL0_NAND_NINT 0 NMOS l=1.8e-07 w=5e-07

MSEL0_NAND_N2 SEL0_NAND_NINT S0_bar 0 0 NMOS l=1.8e-07 w=5e-07

MSEL0_INV_P SEL0 SEL0_NAND_OUT Vdd Vdd PMOS l=1.8e-07 w=1e-06

MSEL0_INV_N SEL0 SEL0_NAND_OUT 0 0 NMOS l=1.8e-07 w=5e-07

MSEL1_NAND_P1 SEL1_NAND_OUT S1_bar Vdd Vdd PMOS l=1.8e-07 w=1e-06

MSEL1_NAND_P2 SEL1_NAND_OUT S0 Vdd Vdd PMOS l=1.8e-07 w=1e-06

MSEL1_NAND_N1 SEL1_NAND_OUT S1_bar SEL1_NAND_NINT 0 NMOS l=1.8e-07 w=5e-07

MSEL1_NAND_N2 SEL1_NAND_NINT S0 0 0 NMOS l=1.8e-07 w=5e-07

MSEL1_INV_P SEL1 SEL1_NAND_OUT Vdd Vdd PMOS l=1.8e-07 w=1e-06

MSEL1_INV_N SEL1 SEL1_NAND_OUT 0 0 NMOS l=1.8e-07 w=5e-07

MSEL2_NAND_P1 SEL2_NAND_OUT S1 Vdd Vdd PMOS l=1.8e-07 w=1e-06

MSEL2_NAND_P2 SEL2_NAND_OUT S0_bar Vdd Vdd PMOS l=1.8e-07 w=1e-06

MSEL2_NAND_N1 SEL2_NAND_OUT S1 SEL2_NAND_NINT 0 NMOS l=1.8e-07 w=5e-07

MSEL2_NAND_N2 SEL2_NAND_NINT S0_bar 0 0 NMOS l=1.8e-07 w=5e-07

MSEL2_INV_P SEL2 SEL2_NAND_OUT Vdd Vdd PMOS l=1.8e-07 w=1e-06

MSEL2_INV_N SEL2 SEL2_NAND_OUT 0 0 NMOS l=1.8e-07 w=5e-07

MSEL3_NAND_P1 SEL3_NAND_OUT S1 Vdd Vdd PMOS l=1.8e-07 w=1e-06

MSEL3_NAND_P2 SEL3_NAND_OUT S0 Vdd Vdd PMOS l=1.8e-07 w=1e-06

MSEL3_NAND_N1 SEL3_NAND_OUT S1 SEL3_NAND_NINT 0 NMOS l=1.8e-07 w=5e-07

MSEL3_NAND_N2 SEL3_NAND_NINT S0 0 0 NMOS l=1.8e-07 w=5e-07

MSEL3_INV_P SEL3 SEL3_NAND_OUT Vdd Vdd PMOS l=1.8e-07 w=1e-06

MSEL3_INV_N SEL3 SEL3_NAND_OUT 0 0 NMOS l=1.8e-07 w=5e-07

MINV_SEL0_P SEL0_bar SEL0 Vdd Vdd PMOS l=1.8e-07 w=1e-06

MINV_SEL0_N SEL0_bar SEL0 0 0 NMOS l=1.8e-07 w=5e-07

MINV_SEL1_P SEL1_bar SEL1 Vdd Vdd PMOS l=1.8e-07 w=1e-06

MINV_SEL1_N SEL1_bar SEL1 0 0 NMOS l=1.8e-07 w=5e-07

MINV_SEL2_P SEL2_bar SEL2 Vdd Vdd PMOS l=1.8e-07 w=1e-06

MINV_SEL2_N SEL2_bar SEL2 0 0 NMOS l=1.8e-07 w=5e-07

MINV_SEL3_P SEL3_bar SEL3 Vdd Vdd PMOS l=1.8e-07 w=1e-06

MINV_SEL3_N SEL3_bar SEL3 0 0 NMOS l=1.8e-07 w=5e-07

MTG0_N Vin SEL0 Vout 0 NMOS l=1.8e-07 w=2e-06

MTG0_P Vin SEL0_bar Vout Vdd PMOS l=1.8e-07 w=2e-06

MTG1_N D1 SEL1 Vout 0 NMOS l=1.8e-07 w=2e-06

MTG1_P D1 SEL1_bar Vout Vdd PMOS l=1.8e-07 w=2e-06

MTG2_N D2 SEL2 Vout 0 NMOS l=1.8e-07 w=2e-06

MTG2_P D2 SEL2_bar Vout Vdd PMOS l=1.8e-07 w=2e-06

MTG3_N D3 SEL3 Vout 0 NMOS l=1.8e-07 w=2e-06

MTG3_P D3 SEL3_bar Vout Vdd PMOS l=1.8e-07 w=2e-06

Rload Vout 0 100kOhm

.model NMOS nmos (Vto=0.5 kp=0.0002 lambda=0.02)

.model PMOS pmos (Vto=-0.5 kp=0.0001 lambda=0.02)
